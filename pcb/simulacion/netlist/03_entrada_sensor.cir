.title KiCad schematic
.include "C:/Users/xbox4/Downloads/FT150TS-App-v3.0/pcb/simulacion/modelos.lib"
.tran 1u 3m
V1 /SENSOR GND PULSE( 0 5 0.2m 10u 10u 0.5m 1m )
R20 /SENSOR /GPIO 2.2k
D20 /GPIO /V33 DBAT85
V2 /V33 GND DC 3.3
R99 /V33 /GPIO 45k
.end
